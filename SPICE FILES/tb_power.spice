* CMOS Inverter Power Analysis

.lib /home/praka/whyRD_eda_bundle/open_pdks/sky130/sky130A/libs.tech/ngspice/sky130.lib.spice tt

.include Inverter.spice

* Supply
VDD VDD 0 1.8
VSS VSS 0 0

* Input stimulus
VIN Vin 0 PULSE(0 1.8 0 100p 100p 10n 20n)

* Instantiate extracted inverter
XINV Vout Vin VSS VDD Inverter

* Load capacitance
Cload Vout 0 0.5p

.tran 10p 100n

.control
run

* Waveforms
plot vdd#branch*1000 vout

*-----------------------------------------------
* Power Calculation
*-----------------------------------------------

* Integrate supply current from 20ns to 40ns
meas tran current_integrate integ vdd#branch from=30e-09 to=40e-09

let power_intermidiate = current_integrate*1.8

let average_power = power_intermidiate/(10e-09)

echo "--------------------------------"
echo "Average Power (W)"
print average_power

.endc

.end
