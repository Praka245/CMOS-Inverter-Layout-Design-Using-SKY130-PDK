* SPICE3 file created from Inverter.ext - technology: sky130A

.subckt Inverter Vout Vin VSS VDD

X0 Vout Vin VSS VSS sky130_fd_pr__nfet_01v8 ad=0.18 pd=1.7 as=0.18 ps=1.7 w=0.45 l=0.15
X1 Vout Vin VDD VDD sky130_fd_pr__pfet_01v8 ad=0.2 pd=1.8 as=0.2 ps=1.8 w=1 l=0.15

.ends
